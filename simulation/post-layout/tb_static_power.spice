** sch_path: /home/mveliev/ams/projects/02_cmos_inverter/xschem/simulation/tb_dc.sch
**.subckt tb_dc
VDD VDD 0 1.8
VIN VIN 0 0
x2 VDD VOUT VIN 0 inverter
**** begin user architecture code

.lib /home/mveliev/ams/pdks/share/pdk/sky130A/libs.tech/ngspice/sky130.lib.spice tt

.save all

.dc VIN 0 1.8 0.01

.control
run
	let static_power = v(vdd)*(-i(vdd))

	meas dc static_power_MAX max static_power
	meas dc static_power_HIGH find static_power at=1.8
	meas dc static_power_LOW find static_power at=0

.endc

**** end user architecture code
**.ends

* expanding   symbol:  /home/mveliev/ams/projects/02_cmos_inverter/xschem/simulation/inverter.sym # of pins=4
** sym_path: /home/mveliev/ams/projects/02_cmos_inverter/xschem/simulation/inverter.sym
** sch_path: /home/mveliev/ams/projects/02_cmos_inverter/xschem/simulation/inverter.sch
.subckt inverter VDD VOUT VIN VSS

X0 vout vin vdd vdd sky130_fd_pr__pfet_01v8 ad=2.457 pd=8.42 as=2.457 ps=8.42 w=3.51 l=0.15
X1 vout vin vss vss sky130_fd_pr__nfet_01v8 ad=0.7 pd=3.4 as=0.7 ps=3.4 w=1 l=0.15
C0 vout vin 0.13488f
C1 vin vdd 0.2017f
C2 vout vdd 0.41399f
C3 vout vss 0.64505f
C4 vin vss 0.49202f
C5 vdd vss 2.35663f
.ends
.end
