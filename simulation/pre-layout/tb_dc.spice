** sch_path: /home/mveliev/ams/projects/02_cmos_inverter/xschem/simulation/tb_dc.sch
**.subckt tb_dc
VDD VDD 0 1.8
VIN VIN 0 0
x2 VDD VOUT VIN 0 inverter
**** begin user architecture code

.lib /home/mveliev/ams/pdks/share/pdk/sky130A/libs.tech/ngspice/sky130.lib.spice tt

.save all

.dc VIN 0 1.8 0.01

.control
run
	let static_power = v(vdd)*(-i(vdd))

	meas dc static_power_MAX max static_power
	meas dc static_power_HIGH find static_power at=1.8
	meas dc static_power_LOW find static_power at=0

.endc

**** end user architecture code
**.ends

* expanding   symbol:  /home/mveliev/ams/projects/02_cmos_inverter/xschem/simulation/inverter.sym # of pins=4
** sym_path: /home/mveliev/ams/projects/02_cmos_inverter/xschem/simulation/inverter.sym
** sch_path: /home/mveliev/ams/projects/02_cmos_inverter/xschem/simulation/inverter.sch
.subckt inverter VDD VOUT VIN VSS
*.opin VOUT
*.ipin VIN
*.ipin VDD
*.ipin VSS
XM1 VOUT VIN VDD VDD sky130_fd_pr__pfet_01v8 L=0.15 W=3.51 nf=1 ad=1.0179 as=1.0179 pd=7.6 ps=7.6 nrd=0.0826210826210826
+ nrs=0.0826210826210826 sa=0 sb=0 sd=0 mult=1
XM2 VOUT VIN VSS GND sky130_fd_pr__nfet_01v8 L=0.15 W=1 nf=1 ad=0.29 as=0.29 pd=2.58 ps=2.58 nrd=0.29 nrs=0.29 sa=0 sb=0 sd=0
+ mult=1
.ends

.end
