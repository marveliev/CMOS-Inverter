** sch_path: /home/mveliev/ams/projects/02_cmos_inverter/xschem/simulation/tb_tran.sch
**.subckt tb_tran
VDD VDD 0 1.8
VIN VIN 0 PULSE(0 1.8 0 20p 20p 5n 10n)
C_load VOUT 0 20f
x1 VDD VOUT VIN 0 inverter
**** begin user architecture code

.lib /home/mveliev/ams/pdks/share/pdk/sky130A/libs.tech/ngspice/sky130.lib.spice tt

	.save all

	.temp -40
	.tran 0.5p 50n

	.control
	run
		meas tran tPHL trig VIN val=0.9 rise=2 targ VOUT val=0.9 fall=2
		meas tran tPLH trig VIN val=0.9 fall=2 targ VOUT val=0.9 rise=2

		meas tran vin_rise trig VIN val=0.18 rise=2 targ VIN val=1.62 rise=2
		meas tran vin_fall trig VIN val=1.62 fall=2 targ VIN val=0.18 fall=2

		meas tran vout_rise trig VOUT val=0.18 rise=2 targ VOUT val=1.62 rise=2
		meas tran vout_fall trig VOUT val=1.62 fall=2 targ VOUT val=0.18 fall=2
.endc

**** end user architecture code
**.ends

* expanding   symbol:  /home/mveliev/ams/projects/02_cmos_inverter/xschem/simulation/inverter.sym # of pins=4
** sym_path: /home/mveliev/ams/projects/02_cmos_inverter/xschem/simulation/inverter.sym
.subckt inverter VDD VOUT VIN VSS
*.opin VOUT
*.ipin VIN
*.ipin VDD
*.ipin VSS
XM1 VOUT VIN VDD VDD sky130_fd_pr__pfet_01v8 L=0.15 W=3.51 nf=1 ad=1.0179 as=1.0179 pd=7.6 ps=7.6 nrd=0.0826210826210826
+ nrs=0.0826210826210826 sa=0 sb=0 sd=0 mult=1
XM2 VOUT VIN VSS GND sky130_fd_pr__nfet_01v8 L=0.15 W=1 nf=1 ad=0.29 as=0.29 pd=2.58 ps=2.58 nrd=0.29 nrs=0.29 sa=0 sb=0 sd=0
+ mult=1
.ends
.end
