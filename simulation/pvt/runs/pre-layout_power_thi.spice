** sch_path: /home/mveliev/ams/projects/02_cmos_inverter/xschem/simulation/tb_tran.sch
**.subckt tb_tran
VDD VDD 0 1.8
VIN VIN 0 PULSE(0 1.8 0 20p 20p 5n 10n)
C_load VOUT 0 20f
x1 VDD VOUT VIN 0 inverter
**** begin user architecture code

.lib /home/mveliev/ams/pdks/share/pdk/sky130A/libs.tech/ngspice/sky130.lib.spice tt

.save all

.temp 125
.tran 0.5p 50n

.control
run
	let I_s      = -i(VDD)
	let V_s      =  v(VDD)
	let P_s      =  V_s*I_s

	meas tran   P_avg         AVG       P_s     from=10n to=50n
	meas tran   P_peak        MAX       P_s     from=10n to=50n
	meas tran   E_s           INTEG     P_s     from=10n to=50n

	let E_period = E_s/4

	print P_avg P_peak E_s E_period
	plot  P_s
.endc

**** end user architecture code
**.ends

* expanding   symbol:  /home/mveliev/ams/projects/02_cmos_inverter/xschem/simulation/inverter.sym # of pins=4
** sym_path: /home/mveliev/ams/projects/02_cmos_inverter/xschem/simulation/inverter.sym
.subckt inverter VDD VOUT VIN VSS
*.opin VOUT
*.ipin VIN
*.ipin VDD
*.ipin VSS
XM1 VOUT VIN VDD VDD sky130_fd_pr__pfet_01v8 L=0.15 W=3.51 nf=1 ad=1.0179 as=1.0179 pd=7.6 ps=7.6 nrd=0.0826210826210826
+ nrs=0.0826210826210826 sa=0 sb=0 sd=0 mult=1
XM2 VOUT VIN VSS GND sky130_fd_pr__nfet_01v8 L=0.15 W=1 nf=1 ad=0.29 as=0.29 pd=2.58 ps=2.58 nrd=0.29 nrs=0.29 sa=0 sb=0 sd=0
+ mult=1
.ends
.end
